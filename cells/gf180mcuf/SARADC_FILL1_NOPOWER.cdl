* SARADC_FILL1_NOPOWER (FILL1 of gf180mcuf), cells/tools/build_cells.py
.SUBCKT SARADC_FILL1_NOPOWER
.ENDS
