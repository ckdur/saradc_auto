* SARADC_FILLTIE2 (TAPCELL of gf180mcuf), cells/tools/build_cells.py
.SUBCKT SARADC_FILLTIE2 vdd vss
.ENDS
