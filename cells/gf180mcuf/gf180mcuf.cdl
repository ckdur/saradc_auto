* gf180mcuf float standard cells (stdcell-gen), cells/tools/build_cells.py

.SUBCKT gf180mcuf_INVD0 i vdd vss zn
MU1_M_u2 zn i vss vss nfet_03v3 l=2.800e-07 w=4.000e-07
MU1_M_u3 zn i vdd vdd pfet_03v3 l=2.800e-07 w=7.000e-07
.ENDS

.SUBCKT gf180mcuf_INVD1 i z vss vdd
M0 z i vss vss nfet_03v3 l=2.800e-07 w=8.000e-07
M1 z i vdd vdd pfet_03v3 l=2.800e-07 w=1.400e-06
.ENDS

.SUBCKT gf180mcuf_INVD6 i vdd vss zn
MU1_M_u2_0 zn i vss vss nfet_03v3 l=2.800e-07 w=8.000e-07 $pos=0 $flip=0
MU1_M_u2_1 zn i vss vss nfet_03v3 l=2.800e-07 w=8.000e-07 $pos=1 $flip=1
MU1_M_u2_2 zn i vss vss nfet_03v3 l=2.800e-07 w=8.000e-07 $pos=2 $flip=0
MU1_M_u2_3 zn i vss vss nfet_03v3 l=2.800e-07 w=8.000e-07 $pos=3 $flip=1
MU1_M_u2_4 zn i vss vss nfet_03v3 l=2.800e-07 w=8.000e-07 $pos=4 $flip=0
MU1_M_u2_5 zn i vss vss nfet_03v3 l=2.800e-07 w=8.000e-07 $pos=5 $flip=1
MU1_M_u3_0 zn i vdd vdd pfet_03v3 l=2.800e-07 w=1.400e-06 $pos=0 $flip=0
MU1_M_u3_1 zn i vdd vdd pfet_03v3 l=2.800e-07 w=1.400e-06 $pos=1 $flip=1
MU1_M_u3_2 zn i vdd vdd pfet_03v3 l=2.800e-07 w=1.400e-06 $pos=2 $flip=0
MU1_M_u3_3 zn i vdd vdd pfet_03v3 l=2.800e-07 w=1.400e-06 $pos=3 $flip=1
MU1_M_u3_4 zn i vdd vdd pfet_03v3 l=2.800e-07 w=1.400e-06 $pos=4 $flip=0
MU1_M_u3_5 zn i vdd vdd pfet_03v3 l=2.800e-07 w=1.400e-06 $pos=5 $flip=1
.ENDS

.SUBCKT gf180mcuf_INVD8 i vdd vss zn
MU1_M_u2_0 zn i vss vss nfet_03v3 l=2.800e-07 w=8.000e-07 $pos=0 $flip=0
MU1_M_u2_1 zn i vss vss nfet_03v3 l=2.800e-07 w=8.000e-07 $pos=1 $flip=1
MU1_M_u2_2 zn i vss vss nfet_03v3 l=2.800e-07 w=8.000e-07 $pos=2 $flip=0
MU1_M_u2_3 zn i vss vss nfet_03v3 l=2.800e-07 w=8.000e-07 $pos=3 $flip=1
MU1_M_u2_4 zn i vss vss nfet_03v3 l=2.800e-07 w=8.000e-07 $pos=4 $flip=0
MU1_M_u2_5 zn i vss vss nfet_03v3 l=2.800e-07 w=8.000e-07 $pos=5 $flip=1
MU1_M_u2_6 zn i vss vss nfet_03v3 l=2.800e-07 w=8.000e-07 $pos=6 $flip=0
MU1_M_u2_7 zn i vss vss nfet_03v3 l=2.800e-07 w=8.000e-07 $pos=7 $flip=1
MU1_M_u3_0 zn i vdd vdd pfet_03v3 l=2.800e-07 w=1.400e-06 $pos=0 $flip=0
MU1_M_u3_1 zn i vdd vdd pfet_03v3 l=2.800e-07 w=1.400e-06 $pos=1 $flip=1
MU1_M_u3_2 zn i vdd vdd pfet_03v3 l=2.800e-07 w=1.400e-06 $pos=2 $flip=0
MU1_M_u3_3 zn i vdd vdd pfet_03v3 l=2.800e-07 w=1.400e-06 $pos=3 $flip=1
MU1_M_u3_4 zn i vdd vdd pfet_03v3 l=2.800e-07 w=1.400e-06 $pos=4 $flip=0
MU1_M_u3_5 zn i vdd vdd pfet_03v3 l=2.800e-07 w=1.400e-06 $pos=5 $flip=1
MU1_M_u3_6 zn i vdd vdd pfet_03v3 l=2.800e-07 w=1.400e-06 $pos=6 $flip=0
MU1_M_u3_7 zn i vdd vdd pfet_03v3 l=2.800e-07 w=1.400e-06 $pos=7 $flip=1
.ENDS

.SUBCKT gf180mcuf_INVD12 i vdd vss zn
MU1_M_u2_0 zn i vss vss nfet_03v3 l=2.800e-07 w=8.000e-07 $pos=0 $flip=0
MU1_M_u2_1 zn i vss vss nfet_03v3 l=2.800e-07 w=8.000e-07 $pos=1 $flip=1
MU1_M_u2_2 zn i vss vss nfet_03v3 l=2.800e-07 w=8.000e-07 $pos=2 $flip=0
MU1_M_u2_3 zn i vss vss nfet_03v3 l=2.800e-07 w=8.000e-07 $pos=3 $flip=1
MU1_M_u2_4 zn i vss vss nfet_03v3 l=2.800e-07 w=8.000e-07 $pos=4 $flip=0
MU1_M_u2_5 zn i vss vss nfet_03v3 l=2.800e-07 w=8.000e-07 $pos=5 $flip=1
MU1_M_u2_6 zn i vss vss nfet_03v3 l=2.800e-07 w=8.000e-07 $pos=6 $flip=0
MU1_M_u2_7 zn i vss vss nfet_03v3 l=2.800e-07 w=8.000e-07 $pos=7 $flip=1
MU1_M_u2_8 zn i vss vss nfet_03v3 l=2.800e-07 w=8.000e-07 $pos=8 $flip=0
MU1_M_u2_9 zn i vss vss nfet_03v3 l=2.800e-07 w=8.000e-07 $pos=9 $flip=1
MU1_M_u2_10 zn i vss vss nfet_03v3 l=2.800e-07 w=8.000e-07 $pos=10 $flip=0
MU1_M_u2_11 zn i vss vss nfet_03v3 l=2.800e-07 w=8.000e-07 $pos=11 $flip=1
MU1_M_u3_0 zn i vdd vdd pfet_03v3 l=2.800e-07 w=1.400e-06 $pos=0 $flip=0
MU1_M_u3_1 zn i vdd vdd pfet_03v3 l=2.800e-07 w=1.400e-06 $pos=1 $flip=1
MU1_M_u3_2 zn i vdd vdd pfet_03v3 l=2.800e-07 w=1.400e-06 $pos=2 $flip=0
MU1_M_u3_3 zn i vdd vdd pfet_03v3 l=2.800e-07 w=1.400e-06 $pos=3 $flip=1
MU1_M_u3_4 zn i vdd vdd pfet_03v3 l=2.800e-07 w=1.400e-06 $pos=4 $flip=0
MU1_M_u3_5 zn i vdd vdd pfet_03v3 l=2.800e-07 w=1.400e-06 $pos=5 $flip=1
MU1_M_u3_6 zn i vdd vdd pfet_03v3 l=2.800e-07 w=1.400e-06 $pos=6 $flip=0
MU1_M_u3_7 zn i vdd vdd pfet_03v3 l=2.800e-07 w=1.400e-06 $pos=7 $flip=1
MU1_M_u3_8 zn i vdd vdd pfet_03v3 l=2.800e-07 w=1.400e-06 $pos=8 $flip=0
MU1_M_u3_9 zn i vdd vdd pfet_03v3 l=2.800e-07 w=1.400e-06 $pos=9 $flip=1
MU1_M_u3_10 zn i vdd vdd pfet_03v3 l=2.800e-07 w=1.400e-06 $pos=10 $flip=0
MU1_M_u3_11 zn i vdd vdd pfet_03v3 l=2.800e-07 w=1.400e-06 $pos=11 $flip=1
.ENDS

.SUBCKT gf180mcuf_BUFFD0 i vdd vss z
M_u3_M_u2 z net6 vss vss nfet_03v3 l=2.800e-07 w=2.800e-07
M_u2_M_u2 net6 i vss vss nfet_03v3 l=2.800e-07 w=2.700e-07
M_u3_M_u3 z net6 vdd vdd pfet_03v3 l=2.800e-07 w=6.850e-07
M_u2_M_u3 net6 i vdd vdd pfet_03v3 l=2.800e-07 w=4.200e-07
.ENDS

.SUBCKT gf180mcuf_BUFFD1 i vdd vss z
M_u3_M_u2 z net8 vss vss nfet_03v3 l=2.800e-07 w=8.000e-07
M_u2_M_u2 net8 i vss vss nfet_03v3 l=2.800e-07 w=4.000e-07
M_u3_M_u3 z net8 vdd vdd pfet_03v3 l=2.800e-07 w=1.400e-06
M_u2_M_u3 net8 i vdd vdd pfet_03v3 l=2.800e-07 w=7.000e-07
.ENDS

.SUBCKT gf180mcuf_BUFFD2 i vdd vss z
M_u2_M_u2 net8 i vss vss nfet_03v3 l=2.800e-07 w=8.000e-07
M_u3_0_M_u2 z net8 vss vss nfet_03v3 l=2.800e-07 w=8.000e-07
M_u3_1_M_u2 z net8 vss vss nfet_03v3 l=2.800e-07 w=8.000e-07
M_u2_M_u3 net8 i vdd vdd pfet_03v3 l=2.800e-07 w=1.400e-06
M_u3_0_M_u3 z net8 vdd vdd pfet_03v3 l=2.800e-07 w=1.400e-06
M_u3_1_M_u3 z net8 vdd vdd pfet_03v3 l=2.800e-07 w=1.400e-06
.ENDS

.SUBCKT gf180mcuf_BUFFD4 i vdd vss z
M_u3_0_M_u2 z p0 vss vss nfet_03v3 l=2.800e-07 w=8.000e-07
M_u3_1_M_u2 z p0 vss vss nfet_03v3 l=2.800e-07 w=8.000e-07
M_u3_2_M_u2 z p0 vss vss nfet_03v3 l=2.800e-07 w=8.000e-07
M_u3_3_M_u2 z p0 vss vss nfet_03v3 l=2.800e-07 w=8.000e-07
M_u2_0_M_u2 p0 i vss vss nfet_03v3 l=2.800e-07 w=8.000e-07
M_u2_1_M_u2 p0 i vss vss nfet_03v3 l=2.800e-07 w=8.000e-07
M_u3_0_M_u3 z p0 vdd vdd pfet_03v3 l=2.800e-07 w=1.400e-06
M_u3_1_M_u3 z p0 vdd vdd pfet_03v3 l=2.800e-07 w=1.400e-06
M_u3_2_M_u3 z p0 vdd vdd pfet_03v3 l=2.800e-07 w=1.400e-06
M_u3_3_M_u3 z p0 vdd vdd pfet_03v3 l=2.800e-07 w=1.400e-06
M_u2_0_M_u3 p0 i vdd vdd pfet_03v3 l=2.800e-07 w=1.400e-06
M_u2_1_M_u3 p0 i vdd vdd pfet_03v3 l=2.800e-07 w=1.400e-06
.ENDS

.SUBCKT gf180mcuf_BUFFD8 i vdd vss z
MI1_M_u2 n0 i vss vss nfet_03v3 l=2.800e-07 w=8.000e-07 $pos=0 $flip=0
MI2_M_u2 n0 i vss vss nfet_03v3 l=2.800e-07 w=5.400e-07 $pos=1 $flip=1
M_u2_M_u2 n0 i vss vss nfet_03v3 l=2.800e-07 w=8.000e-07 $pos=2 $flip=0
M_u7_0_M_u2 z n0 vss vss nfet_03v3 l=2.800e-07 w=8.000e-07 $pos=3 $flip=1
M_u7_1_M_u2 z n0 vss vss nfet_03v3 l=2.800e-07 w=8.000e-07 $pos=4 $flip=0
M_u7_2_M_u2 z n0 vss vss nfet_03v3 l=2.800e-07 w=8.000e-07 $pos=5 $flip=1
M_u7_3_M_u2 z n0 vss vss nfet_03v3 l=2.800e-07 w=8.000e-07 $pos=6 $flip=0
M_u7_4_M_u2 z n0 vss vss nfet_03v3 l=2.800e-07 w=8.000e-07 $pos=7 $flip=1
M_u7_5_M_u2 z n0 vss vss nfet_03v3 l=2.800e-07 w=8.000e-07 $pos=8 $flip=0
M_u7_6_M_u2 z n0 vss vss nfet_03v3 l=2.800e-07 w=8.000e-07 $pos=9 $flip=1
M_u7_7_M_u2 z n0 vss vss nfet_03v3 l=2.800e-07 w=8.000e-07 $pos=10 $flip=0
MI1_M_u3 n0 i vdd vdd pfet_03v3 l=2.800e-07 w=1.400e-06 $pos=0 $flip=0
MI2_M_u3 n0 i vdd vdd pfet_03v3 l=2.800e-07 w=9.350e-07 $pos=1 $flip=1
M_u2_M_u3 n0 i vdd vdd pfet_03v3 l=2.800e-07 w=1.400e-06 $pos=2 $flip=0
M_u7_0_M_u3 z n0 vdd vdd pfet_03v3 l=2.800e-07 w=1.400e-06 $pos=3 $flip=1
M_u7_1_M_u3 z n0 vdd vdd pfet_03v3 l=2.800e-07 w=1.400e-06 $pos=4 $flip=0
M_u7_2_M_u3 z n0 vdd vdd pfet_03v3 l=2.800e-07 w=1.400e-06 $pos=5 $flip=1
M_u7_3_M_u3 z n0 vdd vdd pfet_03v3 l=2.800e-07 w=1.400e-06 $pos=6 $flip=0
M_u7_4_M_u3 z n0 vdd vdd pfet_03v3 l=2.800e-07 w=1.400e-06 $pos=7 $flip=1
M_u7_5_M_u3 z n0 vdd vdd pfet_03v3 l=2.800e-07 w=1.400e-06 $pos=8 $flip=0
M_u7_6_M_u3 z n0 vdd vdd pfet_03v3 l=2.800e-07 w=1.400e-06 $pos=9 $flip=1
M_u7_7_M_u3 z n0 vdd vdd pfet_03v3 l=2.800e-07 w=1.400e-06 $pos=10 $flip=0
.ENDS

.SUBCKT gf180mcuf_BUFFD16 i vdd vss z
MI6_M_u2 n0 i vss vss nfet_03v3 l=2.800e-07 w=2.800e-07 $pos=0 $flip=1
M_u2_0_M_u2 n0 i vss vss nfet_03v3 l=2.800e-07 w=8.000e-07 $pos=1 $flip=0
M_u2_1_M_u2 n0 i vss vss nfet_03v3 l=2.800e-07 w=8.000e-07 $pos=2 $flip=1
M_u2_2_M_u2 n0 i vss vss nfet_03v3 l=2.800e-07 w=8.000e-07 $pos=3 $flip=0
M_u2_3_M_u2 n0 i vss vss nfet_03v3 l=2.800e-07 w=8.000e-07 $pos=4 $flip=1
M_u2_4_M_u2 n0 i vss vss nfet_03v3 l=2.800e-07 w=8.000e-07 $pos=5 $flip=0
MU8_0_M_u2 z n0 vss vss nfet_03v3 l=2.800e-07 w=8.000e-07 $pos=6 $flip=1
MU8_1_M_u2 z n0 vss vss nfet_03v3 l=2.800e-07 w=8.000e-07 $pos=7 $flip=0
MU8_2_M_u2 z n0 vss vss nfet_03v3 l=2.800e-07 w=8.000e-07 $pos=8 $flip=1
MU8_3_M_u2 z n0 vss vss nfet_03v3 l=2.800e-07 w=8.000e-07 $pos=9 $flip=0
MU8_4_M_u2 z n0 vss vss nfet_03v3 l=2.800e-07 w=8.000e-07 $pos=10 $flip=1
MU8_5_M_u2 z n0 vss vss nfet_03v3 l=2.800e-07 w=8.000e-07 $pos=11 $flip=0
MU8_6_M_u2 z n0 vss vss nfet_03v3 l=2.800e-07 w=8.000e-07 $pos=12 $flip=1
MU8_7_M_u2 z n0 vss vss nfet_03v3 l=2.800e-07 w=8.000e-07 $pos=13 $flip=0
MU8_8_M_u2 z n0 vss vss nfet_03v3 l=2.800e-07 w=8.000e-07 $pos=14 $flip=1
MU8_9_M_u2 z n0 vss vss nfet_03v3 l=2.800e-07 w=8.000e-07 $pos=15 $flip=0
MU8_10_M_u2 z n0 vss vss nfet_03v3 l=2.800e-07 w=8.000e-07 $pos=16 $flip=1
MU8_11_M_u2 z n0 vss vss nfet_03v3 l=2.800e-07 w=8.000e-07 $pos=17 $flip=0
MU8_12_M_u2 z n0 vss vss nfet_03v3 l=2.800e-07 w=8.000e-07 $pos=18 $flip=1
MU8_13_M_u2 z n0 vss vss nfet_03v3 l=2.800e-07 w=8.000e-07 $pos=19 $flip=0
MU8_14_M_u2 z n0 vss vss nfet_03v3 l=2.800e-07 w=8.000e-07 $pos=20 $flip=1
MU8_15_M_u2 z n0 vss vss nfet_03v3 l=2.800e-07 w=8.000e-07 $pos=21 $flip=0
MI6_M_u3 n0 i vdd vdd pfet_03v3 l=2.800e-07 w=4.650e-07 $pos=0 $flip=1
M_u2_0_M_u3 n0 i vdd vdd pfet_03v3 l=2.800e-07 w=1.400e-06 $pos=1 $flip=0
M_u2_1_M_u3 n0 i vdd vdd pfet_03v3 l=2.800e-07 w=1.400e-06 $pos=2 $flip=1
M_u2_2_M_u3 n0 i vdd vdd pfet_03v3 l=2.800e-07 w=1.400e-06 $pos=3 $flip=0
M_u2_3_M_u3 n0 i vdd vdd pfet_03v3 l=2.800e-07 w=1.400e-06 $pos=4 $flip=1
M_u2_4_M_u3 n0 i vdd vdd pfet_03v3 l=2.800e-07 w=1.400e-06 $pos=5 $flip=0
MU8_0_M_u3 z n0 vdd vdd pfet_03v3 l=2.800e-07 w=1.400e-06 $pos=6 $flip=1
MU8_1_M_u3 z n0 vdd vdd pfet_03v3 l=2.800e-07 w=1.400e-06 $pos=7 $flip=0
MU8_2_M_u3 z n0 vdd vdd pfet_03v3 l=2.800e-07 w=1.400e-06 $pos=8 $flip=1
MU8_3_M_u3 z n0 vdd vdd pfet_03v3 l=2.800e-07 w=1.400e-06 $pos=9 $flip=0
MU8_4_M_u3 z n0 vdd vdd pfet_03v3 l=2.800e-07 w=1.400e-06 $pos=10 $flip=1
MU8_5_M_u3 z n0 vdd vdd pfet_03v3 l=2.800e-07 w=1.400e-06 $pos=11 $flip=0
MU8_6_M_u3 z n0 vdd vdd pfet_03v3 l=2.800e-07 w=1.400e-06 $pos=12 $flip=1
MU8_7_M_u3 z n0 vdd vdd pfet_03v3 l=2.800e-07 w=1.400e-06 $pos=13 $flip=0
MU8_8_M_u3 z n0 vdd vdd pfet_03v3 l=2.800e-07 w=1.400e-06 $pos=14 $flip=1
MU8_9_M_u3 z n0 vdd vdd pfet_03v3 l=2.800e-07 w=1.400e-06 $pos=15 $flip=0
MU8_10_M_u3 z n0 vdd vdd pfet_03v3 l=2.800e-07 w=1.400e-06 $pos=16 $flip=1
MU8_11_M_u3 z n0 vdd vdd pfet_03v3 l=2.800e-07 w=1.400e-06 $pos=17 $flip=0
MU8_12_M_u3 z n0 vdd vdd pfet_03v3 l=2.800e-07 w=1.400e-06 $pos=18 $flip=1
MU8_13_M_u3 z n0 vdd vdd pfet_03v3 l=2.800e-07 w=1.400e-06 $pos=19 $flip=0
MU8_14_M_u3 z n0 vdd vdd pfet_03v3 l=2.800e-07 w=1.400e-06 $pos=20 $flip=1
MU8_15_M_u3 z n0 vdd vdd pfet_03v3 l=2.800e-07 w=1.400e-06 $pos=21 $flip=0
.ENDS

.SUBCKT gf180mcuf_DEL4 i vdd vss z
MI2_M_u2 z net13 vss vss nfet_03v3 l=2.800e-07 w=8.000e-07
MU7_M_u2 net13 net11 vss vss nfet_03v3 l=2.800e-07 w=8.000e-07
MU5_M_u2 net11 net9 vss vss nfet_03v3 l=2.800e-07 w=5.350e-07
MI1_M_u2 net9 i vss vss nfet_03v3 l=2.800e-07 w=8.000e-07
MI2_M_u3 z net13 vdd vdd pfet_03v3 l=2.800e-07 w=1.400e-06
MU7_M_u3 net13 net11 vdd vdd pfet_03v3 l=2.800e-07 w=9.900e-07
MU5_M_u3 net11 net9 vdd vdd pfet_03v3 l=2.800e-07 w=1.400e-06
MI1_M_u3 net9 i vdd vdd pfet_03v3 l=2.800e-07 w=1.400e-06
.ENDS

.SUBCKT gf180mcuf_ND2D1 a1 a2 vdd vss zn
MI1_M_u3 zn a1 xi1_net6 vss nfet_03v3 l=2.800e-07 w=8.000e-07
MI1_M_u4 xi1_net6 a2 vss vss nfet_03v3 l=2.800e-07 w=8.000e-07
MI1_M_u2 zn a2 vdd vdd pfet_03v3 l=2.800e-07 w=1.400e-06
MI1_M_u1 zn a1 vdd vdd pfet_03v3 l=2.800e-07 w=1.400e-06
.ENDS

.SUBCKT gf180mcuf_ND2D2 a1 a2 vdd vss zn
MU3_0_M_u3 zn a1 xu3_0_net6 vss nfet_03v3 l=2.800e-07 w=8.000e-07
MU3_0_M_u4 xu3_0_net6 a2 vss vss nfet_03v3 l=2.800e-07 w=8.000e-07
MU3_1_M_u4 xu3_1_net6 a2 vss vss nfet_03v3 l=2.800e-07 w=8.000e-07
MU3_1_M_u3 zn a1 xu3_1_net6 vss nfet_03v3 l=2.800e-07 w=8.000e-07
MU3_0_M_u2 zn a2 vdd vdd pfet_03v3 l=2.800e-07 w=1.400e-06
MU3_0_M_u1 zn a1 vdd vdd pfet_03v3 l=2.800e-07 w=1.400e-06
MU3_1_M_u2 zn a2 vdd vdd pfet_03v3 l=2.800e-07 w=1.400e-06
MU3_1_M_u1 zn a1 vdd vdd pfet_03v3 l=2.800e-07 w=1.400e-06
.ENDS

.SUBCKT gf180mcuf_ND3D1 a1 a2 a3 vdd vss zn
MI1_M_u4 zn a1 xi1_net10 vss nfet_03v3 l=2.800e-07 w=8.000e-07
MI1_M_u5 xi1_net10 a2 xi1_net13 vss nfet_03v3 l=2.800e-07 w=8.000e-07
MI1_M_u6 xi1_net13 a3 vss vss nfet_03v3 l=2.800e-07 w=8.000e-07
MI1_M_u3 zn a3 vdd vdd pfet_03v3 l=2.800e-07 w=1.400e-06
MI1_M_u1 zn a1 vdd vdd pfet_03v3 l=2.800e-07 w=1.400e-06
MI1_M_u2 zn a2 vdd vdd pfet_03v3 l=2.800e-07 w=1.400e-06
.ENDS

.SUBCKT gf180mcuf_NR2D1 a1 a2 vdd vss zn
MI1_M_u4 zn a1 vss vss nfet_03v3 l=2.800e-07 w=8.000e-07
MI1_M_u3 zn a2 vss vss nfet_03v3 l=2.800e-07 w=8.000e-07
MI1_M_u2 zn a1 xi1_net8 vdd pfet_03v3 l=2.800e-07 w=1.400e-06
MI1_M_u1 xi1_net8 a2 vdd vdd pfet_03v3 l=2.800e-07 w=1.400e-06
.ENDS

.SUBCKT gf180mcuf_NR3D4 a1 a2 a3 vdd vss zn
MI0_M_u4_0 zn a3 vss vss nfet_03v3 l=2.800e-07 w=8.000e-07 $pos=4 $flip=1
MI0_M_u4_1 zn a3 vss vss nfet_03v3 l=2.800e-07 w=8.000e-07 $pos=5 $flip=0
MI0_M_u4_2 zn a3 vss vss nfet_03v3 l=2.800e-07 w=8.000e-07 $pos=6 $flip=1
MI0_M_u4_3 zn a3 vss vss nfet_03v3 l=2.800e-07 w=8.000e-07 $pos=7 $flip=0
MI0_M_u5_0 zn a2 vss vss nfet_03v3 l=2.800e-07 w=8.000e-07 $pos=12 $flip=1
MI0_M_u5_1 zn a2 vss vss nfet_03v3 l=2.800e-07 w=8.000e-07 $pos=13 $flip=0
MI0_M_u5_2 zn a2 vss vss nfet_03v3 l=2.800e-07 w=8.000e-07 $pos=14 $flip=1
MI0_M_u5_3 zn a2 vss vss nfet_03v3 l=2.800e-07 w=8.000e-07 $pos=15 $flip=0
MI0_M_u6_0 zn a1 vss vss nfet_03v3 l=2.800e-07 w=8.000e-07 $pos=17 $flip=1
MI0_M_u6_1 zn a1 vss vss nfet_03v3 l=2.800e-07 w=8.000e-07 $pos=18 $flip=0
MI0_M_u6_2 zn a1 vss vss nfet_03v3 l=2.800e-07 w=8.000e-07 $pos=19 $flip=1
MI0_M_u6_3 zn a1 vss vss nfet_03v3 l=2.800e-07 w=8.000e-07 $pos=20 $flip=0
MI0_M_u1_0 xi0_net9 a3 vdd vdd pfet_03v3 l=2.800e-07 w=1.400e-06 $pos=0 $flip=0
MI0_M_u1_1 xi0_net9 a3 vdd vdd pfet_03v3 l=2.800e-07 w=1.400e-06 $pos=1 $flip=1
MI0_M_u1_2 xi0_net9 a3 vdd vdd pfet_03v3 l=2.800e-07 w=1.400e-06 $pos=2 $flip=0
MI0_M_u1_3 xi0_net9 a3 vdd vdd pfet_03v3 l=2.800e-07 w=1.400e-06 $pos=3 $flip=1
MI0_M_u1_4 xi0_net9 a3 vdd vdd pfet_03v3 l=2.800e-07 w=1.400e-06 $pos=4 $flip=0
MI0_M_u1_5 xi0_net9 a3 vdd vdd pfet_03v3 l=2.800e-07 w=1.400e-06 $pos=5 $flip=1
MI0_M_u1_6 xi0_net9 a3 vdd vdd pfet_03v3 l=2.800e-07 w=1.400e-06 $pos=6 $flip=0
MI0_M_u1_7 xi0_net9 a3 vdd vdd pfet_03v3 l=2.800e-07 w=1.400e-06 $pos=7 $flip=1
MI0_M_u2_0 xi0_net12 a2 xi0_net9 vdd pfet_03v3 l=2.800e-07 w=1.400e-06 $pos=8 $flip=1
MI0_M_u2_1 xi0_net12 a2 xi0_net9 vdd pfet_03v3 l=2.800e-07 w=1.400e-06 $pos=9 $flip=0
MI0_M_u2_2 xi0_net12 a2 xi0_net9 vdd pfet_03v3 l=2.800e-07 w=1.400e-06 $pos=10 $flip=1
MI0_M_u2_3 xi0_net12 a2 xi0_net9 vdd pfet_03v3 l=2.800e-07 w=1.400e-06 $pos=11 $flip=0
MI0_M_u2_4 xi0_net12 a2 xi0_net9 vdd pfet_03v3 l=2.800e-07 w=1.400e-06 $pos=12 $flip=1
MI0_M_u2_5 xi0_net12 a2 xi0_net9 vdd pfet_03v3 l=2.800e-07 w=1.400e-06 $pos=13 $flip=0
MI0_M_u2_6 xi0_net12 a2 xi0_net9 vdd pfet_03v3 l=2.800e-07 w=1.400e-06 $pos=14 $flip=1
MI0_M_u2_7 xi0_net12 a2 xi0_net9 vdd pfet_03v3 l=2.800e-07 w=1.400e-06 $pos=15 $flip=0
MI0_M_u3_0 zn a1 xi0_net12 vdd pfet_03v3 l=2.800e-07 w=1.400e-06 $pos=17 $flip=1
MI0_M_u3_1 zn a1 xi0_net12 vdd pfet_03v3 l=2.800e-07 w=1.400e-06 $pos=18 $flip=0
MI0_M_u3_2 zn a1 xi0_net12 vdd pfet_03v3 l=2.800e-07 w=1.400e-06 $pos=19 $flip=1
MI0_M_u3_3 zn a1 xi0_net12 vdd pfet_03v3 l=2.800e-07 w=1.400e-06 $pos=20 $flip=0
MI0_M_u3_4 zn a1 xi0_net12 vdd pfet_03v3 l=2.800e-07 w=1.400e-06 $pos=21 $flip=1
MI0_M_u3_5 zn a1 xi0_net12 vdd pfet_03v3 l=2.800e-07 w=1.400e-06 $pos=22 $flip=0
MI0_M_u3_6 zn a1 xi0_net12 vdd pfet_03v3 l=2.800e-07 w=1.400e-06 $pos=23 $flip=1
MI0_M_u3_7 zn a1 xi0_net12 vdd pfet_03v3 l=2.800e-07 w=1.400e-06 $pos=24 $flip=0
.ENDS

.SUBCKT gf180mcuf_AN2D1 a1 a2 vdd vss z
M_u2_M_u3 net6 a1 x_u2_net6 vss nfet_03v3 l=2.800e-07 w=7.250e-07
M_u3_M_u2 z net6 vss vss nfet_03v3 l=2.800e-07 w=8.000e-07
M_u2_M_u4 x_u2_net6 a2 vss vss nfet_03v3 l=2.800e-07 w=7.250e-07
M_u3_M_u3 z net6 vdd vdd pfet_03v3 l=2.800e-07 w=1.400e-06
M_u2_M_u2 net6 a2 vdd vdd pfet_03v3 l=2.800e-07 w=1.400e-06
M_u2_M_u1 net6 a1 vdd vdd pfet_03v3 l=2.800e-07 w=1.400e-06
.ENDS

.SUBCKT gf180mcuf_AN2D4 a1 a2 vdd vss z
M_u2_0_M_u3 p0 a1 x_u2_0_net6 vss nfet_03v3 l=2.800e-07 w=8.000e-07
M_u3_0_M_u2 z p0 vss vss nfet_03v3 l=2.800e-07 w=8.000e-07
M_u3_1_M_u2 z p0 vss vss nfet_03v3 l=2.800e-07 w=8.000e-07
M_u3_2_M_u2 z p0 vss vss nfet_03v3 l=2.800e-07 w=8.000e-07
M_u3_3_M_u2 z p0 vss vss nfet_03v3 l=2.800e-07 w=8.000e-07
M_u2_0_M_u4 x_u2_0_net6 a2 vss vss nfet_03v3 l=2.800e-07 w=8.000e-07
M_u2_1_M_u4 x_u2_1_net6 a2 vss vss nfet_03v3 l=2.800e-07 w=8.000e-07
M_u2_1_M_u3 p0 a1 x_u2_1_net6 vss nfet_03v3 l=2.800e-07 w=8.000e-07
M_u3_0_M_u3 z p0 vdd vdd pfet_03v3 l=2.800e-07 w=1.400e-06
M_u3_1_M_u3 z p0 vdd vdd pfet_03v3 l=2.800e-07 w=1.400e-06
M_u3_2_M_u3 z p0 vdd vdd pfet_03v3 l=2.800e-07 w=1.400e-06
M_u3_3_M_u3 z p0 vdd vdd pfet_03v3 l=2.800e-07 w=1.400e-06
M_u2_0_M_u2 p0 a2 vdd vdd pfet_03v3 l=2.800e-07 w=1.400e-06
M_u2_0_M_u1 p0 a1 vdd vdd pfet_03v3 l=2.800e-07 w=1.400e-06
M_u2_1_M_u2 p0 a2 vdd vdd pfet_03v3 l=2.800e-07 w=1.400e-06
M_u2_1_M_u1 p0 a1 vdd vdd pfet_03v3 l=2.800e-07 w=1.400e-06
.ENDS

.SUBCKT gf180mcuf_OR2D1 a1 a2 vdd vss z
MU1_M_u2 z net7 vss vss nfet_03v3 l=2.800e-07 w=7.250e-07
M_u7_M_u4 net7 a1 vss vss nfet_03v3 l=2.800e-07 w=7.250e-07
M_u7_M_u3 net7 a2 vss vss nfet_03v3 l=2.800e-07 w=7.250e-07
M_u7_M_u2 net7 a1 x_u7_net8 vdd pfet_03v3 l=2.800e-07 w=1.400e-06
MU1_M_u3 z net7 vdd vdd pfet_03v3 l=2.800e-07 w=1.400e-06
M_u7_M_u1 x_u7_net8 a2 vdd vdd pfet_03v3 l=2.800e-07 w=1.400e-06
.ENDS

.SUBCKT gf180mcuf_AO21D1 a1 a2 b vdd vss z
MI7 net32 a2 vss vss nfet_03v3 l=2.800e-07 w=8.000e-07
M_u7 net59 a1 net32 vss nfet_03v3 l=2.800e-07 w=8.000e-07
MI6 net59 b vss vss nfet_03v3 l=2.800e-07 w=8.000e-07
MI8_M_u2 z net59 vss vss nfet_03v3 l=2.800e-07 w=8.000e-07
M_u3 net22 a1 net59 vdd pfet_03v3 l=2.800e-07 w=1.400e-06
MI8_M_u3 z net59 vdd vdd pfet_03v3 l=2.800e-07 w=1.400e-06
M_u4 net22 a2 net59 vdd pfet_03v3 l=2.800e-07 w=1.400e-06
M_u2 net22 b vdd vdd pfet_03v3 l=2.800e-07 w=1.400e-06
.ENDS

.SUBCKT gf180mcuf_OA21D1 a1 a2 b vdd vss z
MI12 net14 a2 net20 vss nfet_03v3 l=2.800e-07 w=8.000e-07
MI11 net14 a1 net20 vss nfet_03v3 l=2.800e-07 w=8.000e-07
MI6 net20 b vss vss nfet_03v3 l=2.800e-07 w=8.000e-07
MI8_M_u2 z net14 vss vss nfet_03v3 l=2.800e-07 w=8.000e-07
MI9 net14 a1 net24 vdd pfet_03v3 l=2.800e-07 w=1.400e-06
MI8_M_u3 z net14 vdd vdd pfet_03v3 l=2.800e-07 w=1.400e-06
M_u2 net14 b vdd vdd pfet_03v3 l=2.800e-07 w=1.400e-06
MI7 net24 a2 vdd vdd pfet_03v3 l=2.800e-07 w=1.400e-06
.ENDS

.SUBCKT gf180mcuf_AOI21D1 a1 a2 b vdd vss zn
MI2 zn a1 net27 vss nfet_03v3 l=2.800e-07 w=8.000e-07
MI3 net27 a2 vss vss nfet_03v3 l=2.800e-07 w=8.000e-07
M_u7 zn b vss vss nfet_03v3 l=2.800e-07 w=8.000e-07
M_u4 net13 a2 zn vdd pfet_03v3 l=2.800e-07 w=1.400e-06
M_u2 net13 b vdd vdd pfet_03v3 l=2.800e-07 w=1.400e-06
M_u3 net13 a1 zn vdd pfet_03v3 l=2.800e-07 w=1.400e-06
.ENDS

.SUBCKT gf180mcuf_OAI21D1 a1 a2 b vdd vss zn
M_u2 zn a1 net15 vss nfet_03v3 l=2.800e-07 w=8.000e-07
M_u3 zn a2 net15 vss nfet_03v3 l=2.800e-07 w=8.000e-07
M_u4 net15 b vss vss nfet_03v3 l=2.800e-07 w=8.000e-07
MI16_MI12 zn a1 xi16_net11 vdd pfet_03v3 l=2.800e-07 w=1.400e-06
M_u9 zn b vdd vdd pfet_03v3 l=2.800e-07 w=1.400e-06
MI16_MI13 xi16_net11 a2 vdd vdd pfet_03v3 l=2.800e-07 w=1.400e-06
.ENDS

.SUBCKT gf180mcuf_OAI211D4 a1 a2 b c vdd vss zn
MI13_0 zn a2 net36 vss nfet_03v3 l=2.800e-07 w=8.000e-07 $pos=0 $flip=0
MI13_1 zn a2 net36 vss nfet_03v3 l=2.800e-07 w=8.000e-07 $pos=1 $flip=1
MI13_2 zn a2 net36 vss nfet_03v3 l=2.800e-07 w=8.000e-07 $pos=2 $flip=0
MI13_3 zn a2 net36 vss nfet_03v3 l=2.800e-07 w=8.000e-07 $pos=3 $flip=1
MI14_0 zn a1 net36 vss nfet_03v3 l=2.800e-07 w=8.000e-07 $pos=4 $flip=0
MI14_1 zn a1 net36 vss nfet_03v3 l=2.800e-07 w=8.000e-07 $pos=5 $flip=1
MI14_2 zn a1 net36 vss nfet_03v3 l=2.800e-07 w=8.000e-07 $pos=6 $flip=0
MI14_3 zn a1 net36 vss nfet_03v3 l=2.800e-07 w=8.000e-07 $pos=7 $flip=1
MI2_0 net36 b net24 vss nfet_03v3 l=2.800e-07 w=8.000e-07 $pos=9 $flip=1
MI2_1 net36 b net24 vss nfet_03v3 l=2.800e-07 w=8.000e-07 $pos=10 $flip=0
MI2_2 net36 b net24 vss nfet_03v3 l=2.800e-07 w=8.000e-07 $pos=11 $flip=1
MI2_3 net36 b net24 vss nfet_03v3 l=2.800e-07 w=8.000e-07 $pos=12 $flip=0
MI12_0 net24 c vss vss nfet_03v3 l=2.800e-07 w=8.000e-07 $pos=13 $flip=0
MI12_1 net24 c vss vss nfet_03v3 l=2.800e-07 w=8.000e-07 $pos=14 $flip=1
MI12_2 net24 c vss vss nfet_03v3 l=2.800e-07 w=8.000e-07 $pos=15 $flip=0
MI12_3 net24 c vss vss nfet_03v3 l=2.800e-07 w=8.000e-07 $pos=16 $flip=1
MI11_0 zn a2 net35 vdd pfet_03v3 l=2.800e-07 w=1.400e-06 $pos=0 $flip=1
MI11_1 zn a2 net35 vdd pfet_03v3 l=2.800e-07 w=1.400e-06 $pos=1 $flip=0
MI11_2 zn a2 net35 vdd pfet_03v3 l=2.800e-07 w=1.400e-06 $pos=2 $flip=1
MI11_3 zn a2 net35 vdd pfet_03v3 l=2.800e-07 w=1.400e-06 $pos=3 $flip=0
MI9_0 net35 a1 vdd vdd pfet_03v3 l=2.800e-07 w=1.400e-06 $pos=5 $flip=1
MI9_1 net35 a1 vdd vdd pfet_03v3 l=2.800e-07 w=1.400e-06 $pos=6 $flip=0
MI9_2 net35 a1 vdd vdd pfet_03v3 l=2.800e-07 w=1.400e-06 $pos=7 $flip=1
MI9_3 net35 a1 vdd vdd pfet_03v3 l=2.800e-07 w=1.400e-06 $pos=8 $flip=0
M_u12_0 zn b vdd vdd pfet_03v3 l=2.800e-07 w=1.400e-06 $pos=9 $flip=1
M_u12_1 zn b vdd vdd pfet_03v3 l=2.800e-07 w=1.400e-06 $pos=10 $flip=0
M_u12_2 zn b vdd vdd pfet_03v3 l=2.800e-07 w=1.400e-06 $pos=11 $flip=1
M_u12_3 zn b vdd vdd pfet_03v3 l=2.800e-07 w=1.400e-06 $pos=12 $flip=0
MI8_0 zn c vdd vdd pfet_03v3 l=2.800e-07 w=1.400e-06 $pos=13 $flip=1
MI8_1 zn c vdd vdd pfet_03v3 l=2.800e-07 w=1.400e-06 $pos=14 $flip=0
MI8_2 zn c vdd vdd pfet_03v3 l=2.800e-07 w=1.400e-06 $pos=15 $flip=1
MI8_3 zn c vdd vdd pfet_03v3 l=2.800e-07 w=1.400e-06 $pos=16 $flip=0
.ENDS

.SUBCKT gf180mcuf_XOR2D1 a1 a2 vdd vss z
MI6_M_u3 net41 a1 net21 vss nfet_03v3 l=2.800e-07 w=4.000e-07
MI2_M_u3 net27 net23 net21 vss nfet_03v3 l=2.800e-07 w=4.000e-07
MI7_M_u2 net41 net27 vss vss nfet_03v3 l=2.800e-07 w=4.000e-07
MI3_M_u2 net27 a2 vss vss nfet_03v3 l=2.800e-07 w=8.000e-07
MI4_M_u2 z net21 vss vss nfet_03v3 l=2.800e-07 w=8.000e-07
MI5_M_u2 net23 a1 vss vss nfet_03v3 l=2.800e-07 w=4.000e-07
MI6_M_u2 net41 net23 net21 vdd pfet_03v3 l=2.800e-07 w=7.000e-07
MI2_M_u2 net27 a1 net21 vdd pfet_03v3 l=2.800e-07 w=7.000e-07
MI7_M_u3 net41 net27 vdd vdd pfet_03v3 l=2.800e-07 w=7.000e-07
MI3_M_u3 net27 a2 vdd vdd pfet_03v3 l=2.800e-07 w=1.400e-06
MI4_M_u3 z net21 vdd vdd pfet_03v3 l=2.800e-07 w=1.400e-06
MI5_M_u3 net23 a1 vdd vdd pfet_03v3 l=2.800e-07 w=7.000e-07
.ENDS

.SUBCKT gf180mcuf_XNR2D1 a1 a2 vdd vss zn
M_u2_M_u2 net4 a2 vss vss nfet_03v3 l=2.800e-07 w=8.000e-07
M_u5_M_u2 net6 net4 vss vss nfet_03v3 l=2.800e-07 w=4.000e-07
M_u4_M_u2 zn net14 vss vss nfet_03v3 l=2.800e-07 w=8.000e-07
M_u8_M_u2 net10 a1 vss vss nfet_03v3 l=2.800e-07 w=4.000e-07
M_u6_M_u3 net4 a1 net14 vss nfet_03v3 l=2.800e-07 w=4.000e-07
M_u7_M_u3 net6 net10 net14 vss nfet_03v3 l=2.800e-07 w=4.000e-07
M_u6_M_u2 net4 net10 net14 vdd pfet_03v3 l=2.800e-07 w=7.000e-07
M_u2_M_u3 net4 a2 vdd vdd pfet_03v3 l=2.800e-07 w=1.400e-06
M_u5_M_u3 net6 net4 vdd vdd pfet_03v3 l=2.800e-07 w=7.000e-07
M_u4_M_u3 zn net14 vdd vdd pfet_03v3 l=2.800e-07 w=1.400e-06
M_u8_M_u3 net10 a1 vdd vdd pfet_03v3 l=2.800e-07 w=7.000e-07
M_u7_M_u2 net6 a1 net14 vdd pfet_03v3 l=2.800e-07 w=7.000e-07
.ENDS

.SUBCKT gf180mcuf_MUX2D1 i0 i1 s vdd vss z
MI15_M_u3 net46 s net28 vss nfet_03v3 l=2.800e-07 w=4.000e-07
MU7_M_u3 net48 net42 net28 vss nfet_03v3 l=2.800e-07 w=4.000e-07
MI20_M_u2 net46 i1 vss vss nfet_03v3 l=2.800e-07 w=8.000e-07
MI19_M_u2 net48 i0 vss vss nfet_03v3 l=2.800e-07 w=5.750e-07
MI18_M_u2 net42 s vss vss nfet_03v3 l=2.800e-07 w=4.000e-07
MU29_M_u2 z net28 vss vss nfet_03v3 l=2.800e-07 w=8.000e-07
MI15_M_u2 net46 net42 net28 vdd pfet_03v3 l=2.800e-07 w=7.000e-07
MU7_M_u2 net48 s net28 vdd pfet_03v3 l=2.800e-07 w=7.000e-07
MI20_M_u3 net46 i1 vdd vdd pfet_03v3 l=2.800e-07 w=1.400e-06
MI19_M_u3 net48 i0 vdd vdd pfet_03v3 l=2.800e-07 w=1.155e-06
MI18_M_u3 net42 s vdd vdd pfet_03v3 l=2.800e-07 w=7.000e-07
MU29_M_u3 z net28 vdd vdd pfet_03v3 l=2.800e-07 w=9.800e-07
.ENDS

.SUBCKT gf180mcuf_DFQD1 cp d q vdd vss
MI4 net43 incpb vss vss nfet_03v3 l=2.800e-07 w=4.650e-07
MI23 d2 incpb net42 vss nfet_03v3 l=2.800e-07 w=2.800e-07
MI5 d0 d net43 vss nfet_03v3 l=2.800e-07 w=4.650e-07
MI47 d0 incp net50 vss nfet_03v3 l=2.800e-07 w=2.800e-07
MI48 net50 d1 vss vss nfet_03v3 l=2.800e-07 w=2.800e-07
MI24 net42 d3 vss vss nfet_03v3 l=2.800e-07 w=2.800e-07
MI50 d1 incp d2 vss nfet_03v3 l=2.800e-07 w=4.300e-07
MI32_M_u2 incp incpb vss vss nfet_03v3 l=2.800e-07 w=8.000e-07
MI31_M_u2 incpb cp vss vss nfet_03v3 l=2.800e-07 w=8.000e-07
MI27_M_u2 q d3 vss vss nfet_03v3 l=2.800e-07 w=8.000e-07
MI53_M_u2 d3 d2 vss vss nfet_03v3 l=2.800e-07 w=8.000e-07
MI13_M_u2 d1 d0 vss vss nfet_03v3 l=2.800e-07 w=5.200e-07
MI6 d0 d net66 vdd pfet_03v3 l=2.800e-07 w=8.750e-07
MI32_M_u3 incp incpb vdd vdd pfet_03v3 l=2.800e-07 w=1.400e-06
MI31_M_u3 incpb cp vdd vdd pfet_03v3 l=2.800e-07 w=1.400e-06
MI27_M_u3 q d3 vdd vdd pfet_03v3 l=2.800e-07 w=1.400e-06
MI53_M_u3 d3 d2 vdd vdd pfet_03v3 l=2.800e-07 w=1.400e-06
MI13_M_u3 d1 d0 vdd vdd pfet_03v3 l=2.800e-07 w=8.750e-07
MI7 net66 incp vdd vdd pfet_03v3 l=2.800e-07 w=1.030e-06
MI52 d1 incpb d2 vdd pfet_03v3 l=2.800e-07 w=1.240e-06
MI28 net74 d3 vdd vdd pfet_03v3 l=2.800e-07 w=3.550e-07
MI26 d2 incp net74 vdd pfet_03v3 l=2.800e-07 w=3.550e-07
MI45 d0 incpb net84 vdd pfet_03v3 l=2.800e-07 w=3.550e-07
MI43 net84 d1 vdd vdd pfet_03v3 l=2.800e-07 w=3.550e-07
.ENDS

.SUBCKT gf180mcuf_DFCNQD1 cdn cp d q vdd vss
Mcpbn incpb cp vss vss nfet_03v3 l=2.800e-07 w=4.000e-07 $pos=0 $flip=0
Mcpbp incpb cp vdd vdd pfet_03v3 l=2.800e-07 w=7.000e-07 $pos=0 $flip=0
Mcpn incp incpb vss vss nfet_03v3 l=2.800e-07 w=4.000e-07 $pos=1 $flip=1
Mcpp incp incpb vdd vdd pfet_03v3 l=2.800e-07 w=7.000e-07 $pos=1 $flip=1
MI4 net52 incpb vss vss nfet_03v3 l=2.800e-07 w=4.000e-07 $pos=3 $flip=1
MI7 net85 incp vdd vdd pfet_03v3 l=2.800e-07 w=1.030e-06 $pos=3 $flip=1
Mdd0n d0 d net52 vss nfet_03v3 l=2.800e-07 w=4.000e-07 $pos=4 $flip=1
Mdd0p d0 d net85 vdd pfet_03v3 l=2.800e-07 w=1.030e-06 $pos=4 $flip=1
MI47 d0 incp net59 vss nfet_03v3 l=2.800e-07 w=2.800e-07 $pos=5 $flip=0
MI45 d0 incpb net98 vdd pfet_03v3 l=2.800e-07 w=4.200e-07 $pos=5 $flip=0
MI48 net59 d1 net62 vss nfet_03v3 l=2.800e-07 w=2.800e-07 $pos=6 $flip=0
MI43 net98 d1 vdd vdd pfet_03v3 l=2.800e-07 w=3.850e-07 $pos=6 $flip=0
Mcdn0n net62 cdn vss vss nfet_03v3 l=2.800e-07 w=2.800e-07 $pos=7 $flip=0
Md0d1n d1 d0 vss vss nfet_03v3 l=2.800e-07 w=4.950e-07 $pos=8 $flip=1
Mcdn0p net98 cdn vdd vdd pfet_03v3 l=2.800e-07 w=3.550e-07 $pos=8 $flip=0
Mswd1d2n d1 incp d2 vss nfet_03v3 l=2.800e-07 w=5.600e-07 $pos=9 $flip=0
Mdod1p d1 d0 vdd vdd pfet_03v3 l=2.800e-07 w=9.100e-07 $pos=9 $flip=1
MI23 d2 incpb net57 vss nfet_03v3 l=2.800e-07 w=2.800e-07 $pos=10 $flip=0
Mswd1d2p d1 incpb d2 vdd pfet_03v3 l=2.800e-07 w=1.310e-06 $pos=10 $flip=0
MI26 d2 incp net88 vdd pfet_03v3 l=2.800e-07 w=3.550e-07 $pos=11 $flip=0
MI24 net57 d3 vss vss nfet_03v3 l=2.800e-07 w=2.800e-07 $pos=12 $flip=0
MI28 net88 d3 vdd vdd pfet_03v3 l=2.800e-07 w=3.550e-07 $pos=12 $flip=0
Mcdn1n net37 cdn vss vss nfet_03v3 l=2.800e-07 w=8.000e-07 $pos=13 $flip=1
Mcdn1p d3 cdn vdd vdd pfet_03v3 l=2.800e-07 w=1.260e-06 $pos=13 $flip=1
Md2d3n d3 d2 net37 vss nfet_03v3 l=2.800e-07 w=8.000e-07 $pos=14 $flip=1
Md2d3p d3 d2 vdd vdd pfet_03v3 l=2.800e-07 w=1.260e-06 $pos=14 $flip=0
Mobp q d3 vdd vdd pfet_03v3 l=2.800e-07 w=1.400e-06 $pos=15 $flip=1
Mobn q d3 vss vss nfet_03v3 l=2.800e-07 w=8.000e-07 $pos=16 $flip=1
.ENDS

.SUBCKT gf180mcuf_TIEH vdd vss z
M_u2 net6 net6 vss vss nfet_03v3 l=2.800e-07 w=8.000e-07
M_u1 z net6 vdd vdd pfet_03v3 l=2.800e-07 w=1.400e-06
.ENDS

.SUBCKT gf180mcuf_TIEL vdd vss zn
M_u2 zn net6 vss vss nfet_03v3 l=2.800e-07 w=8.000e-07
M_u1 net6 net6 vdd vdd pfet_03v3 l=2.800e-07 w=1.400e-06
.ENDS

.SUBCKT gf180mcuf_FILL1 vdd vss
.ENDS

.SUBCKT gf180mcuf_FILL2 vdd vss
.ENDS

.SUBCKT gf180mcuf_FILL4 vdd vss
.ENDS

.SUBCKT gf180mcuf_FILL8 vdd vss
.ENDS

.SUBCKT gf180mcuf_TAPCELL vdd vss
.ENDS

.SUBCKT gf180mcuf_ANTENNA i vdd vss
DD0 vss i diode_nd2ps_03v3 a=1p p=4u
DD1 i vdd diode_pd2nw_03v3 a=1p p=4u
.ENDS
