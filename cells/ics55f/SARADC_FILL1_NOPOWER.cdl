* SARADC_FILL1_NOPOWER (FILL1 of ics55f), cells/tools/build_cells.py
.SUBCKT SARADC_FILL1_NOPOWER
.ENDS
