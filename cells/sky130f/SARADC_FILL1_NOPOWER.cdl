* SARADC_FILL1_NOPOWER (FILL1 of sky130f), cells/tools/build_cells.py
.SUBCKT SARADC_FILL1_NOPOWER
.ENDS
